// VerilogA for HDL_lab, dac_unclocked, veriloga

`include "constants.vams"
`include "disciplines.vams"

module dac_unclocked(in, out);
	parameter integer BIT_WIDTH = 16;
	parameter real REF_VOLTAGE = 1.2;

	input [15:0] in;
	output out;

	electrical [15:0] in;
	electrical out;

	integer sum;
	real frac;

	analog begin : label
		genvar i;
		sum = 0;
		for(i=0;i<BIT_WIDTH;i=i+1) begin
			sum = sum + (1<<i)*V(in[i])/1.2;
		end
		frac = sum/((1<<BIT_WIDTH) - 1.0);
		V(out) <+ REF_VOLTAGE * frac;
	end

endmodule

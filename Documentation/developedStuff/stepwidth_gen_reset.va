// VerilogA for HDL_lab, stepwidth_gen_reset, veriloga

`include "constants.vams"
`include "disciplines.vams"

module stepwidth_gen_reset(rst, in, out);

	input rst;
	input[15:0] in;
	output[15:0] out;

	electrical rst;
	electrical[15:0] in, out;
	genvar i;
	analog begin
		if (V(rst) > 0.6) begin
			for(i=0; i<16; i = i+1) begin
				if (i == 4) V(out[i]) <+ 1.2;
				else V(out[i]) <+ 0;
			end
		end
		else begin
			for(i=0; i<16; i = i+1) begin
				V(out[i]) <+ V(in[i]);
			end
		end
	end

endmodule
